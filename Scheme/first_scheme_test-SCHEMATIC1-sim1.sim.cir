** Profile: "SCHEMATIC1-sim1"  [ C:\Programming_stuff\graduation_project\Scheme\first_scheme_test-schematic1-sim1.sim ]

** Creating circuit file "first_scheme_test-schematic1-sim1.sim.cir"
** WARNING: THIS AUTOMATICALLY GENERATED FILE MAY BE OVERWRITTEN BY SUBSEQUENT SIMULATIONS

*Libraries:
* Local Libraries :
* From [PSPICE NETLIST] section of C:\Program Files\Orcad\PSpice\PSpice.ini file:
.lib "nom.lib"

*Analysis directives:
.TRAN  0 0.5s 0
.PROBE V(*) I(*) W(*) D(*) NOISE(*)
.INC ".\first_scheme_test-SCHEMATIC1.net"

.END
